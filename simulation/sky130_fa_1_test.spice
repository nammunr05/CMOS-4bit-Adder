* Sky130 Full Adder - Transistor Level Test
.title Sky130 FA1 Typical Corner Simulation

.lib "/home/MACBRUH/open-pdks/sky130/sky130A/libs.tech/ngspice/sky130.lib.spice" tt
.include "/home/MACBRUH/CMOS_4bit_Adder/layout/standard_cell_4bit/reference/sky130_fa_1_extracted.spice"

VA A 0 PULSE(0 1.8 0 10p 10p 4n 8n)
VB B 0 PULSE(0 1.8 0 10p 10p 2n 4n)
VC CIN 0 PULSE(0 1.8 0 10p 10p 1n 2n)

VPOWER VPWR 0 1.8
VNWELL VPB 0 1.8
VGND VGND 0 0
VNBSUB VNB 0 0

XFA A B CIN VGND VNB VPB VPWR COUT SUM sky130_fd_sc_hd__fa_1

.control
set noaskquit
tran 10p 8n
set wr_singlescale
wrdata simulation/sky130_fa_1_results.txt v(A) v(B) v(CIN) v(SUM) v(COUT)
quit
.endc

.end
